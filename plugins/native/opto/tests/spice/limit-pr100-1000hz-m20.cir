* Sonora SPICE reference: optical levelling cell and circuit, limit-pr100-1000hz-m20
* Generated by sonora-dsp-measure --spice-kind opto --spice-generate from common/dsp/opto.h;
* do not edit (plugins/native/measure/include/sonora/measure/spice_opto.h).
VAMP amp 0 PWL(0 0.0087178 0.2 0.0087178 0.200001 0.87178 1.2 0.87178 1.200001 0.0087178 3.2 0.0087178)
BIN in 0 V=v(amp)*sin(6283.185307*time)
R6 in j1 68000
R7 j1 out 2700
R1 out 0 100000
BLDR out 0 I=v(out)*(2e-07+0.0025*v(nc))
EBUF jb 0 j1 0 1
C6 jb s 1e-08
R30 s w0 47000
VR2T w0 w DC 0
R2B w 0 100000
EAMP a 0 w 0 310
VR37 a g DC 0
R3 g 0 1000000
BDRV d 0 V=min(max(v(g),-142),142)
BN 0 nc I=2600*((abs(v(d))>0.006173469388)?exp(-55/sqrt(abs(v(d)))):0)+0.3*v(m1)+0.125*v(m2)-v(nc)/0.047-5*v(nc)*v(nc)-4*v(nc)*(1-v(m1))-1*v(nc)*(1-v(m2))
CNC nc 0 1
BM1 0 m1 I=13.33333333*v(nc)*(1-v(m1))-v(m1)/1
CM1 m1 0 1
BM2 0 m2 I=1*v(nc)*(1-v(m2))-v(m2)/8
CM2 m2 0 1
.ic v(nc)=0 v(m1)=0 v(m2)=0
.options reltol=1e-7 abstol=1e-14 vntol=1e-12 method=trap
.control
tran 1e-05 3.2 0 1e-05 uic
wrdata out.txt v(nc)
.endc
.end
