* Sonora SPICE reference: FET gain-reduction stage and side chain, r20-a0-r866k-10000hz-p6
* Generated by sonora-dsp-measure --spice-kind fet --spice-generate from common/dsp/fet.h;
* do not edit (plugins/native/measure/include/sonora/measure/spice_fet.h).
VAMP amp 0 PWL(0 1.26e-05 0.05 1.26e-05 0.0500001 0.02514030517 0.15 0.02514030517 0.1500001 1.26e-05 0.45 1.26e-05)
BIN in 0 V=v(amp)*sin(62831.85307*time)
R5 in d 27000
J1 d g 0 QFET
.model QFET NJF(BETA=0.001125 VTO=-1.372 LAMBDA=0.0023 IS=1e-30)
BG g 0 V=min((v(c)+v(q))/2,0.5)+v(d)/2
RGQ c q 4400000
C9 q 0 2.2e-07
C22 c 0 2.2e-07
BS s 0 V=max(min(686.9736842*v(d),12),-12)
BA1 a1 0 V=-3.254251921+v(s)
BA2 a2 0 V=-3.254251921-v(s)
D2 a1 w QD
D3 a2 w QD
.model QD D(IS=2.52e-09 N=1.752)
R54 w x 470
C27 w x 2.2e-08
VR55 x c DC 0
RREL c rest 1136000
VREST rest 0 DC -1.364266026
.ic v(c)=-1.369991466 v(q)=-1.369991466 v(w)=-1.369991466 v(x)=-1.369991466
.options reltol=1e-7 abstol=1e-15 vntol=1e-12 method=trap
.control
tran 5e-07 0.45 0 5e-07 uic
wrdata out.txt v(c) v(q)
.endc
.end
