* Sonora SPICE reference: tube stage noise and hum, noise
* Generated by sonora-dsp-measure --spice-generate --spice-kind noise from common/dsp
* triode.h and supply.h; do not edit (plugins/native/measure/include/sonora/measure/spice_noise.h).
VIN in 0 DC 0 AC 1
VBP bp 0 DC 250
CIN in a 2.2e-08
RLEAK a 0 1000000
RGRID a g 22000
RK k 0 1500
CK k 0 2.2e-05
RP bp p 100000
COUT p o 2.2e-08
RL o 0 1000000
CGP g p 2.4e-12
BIP p k I=0.002242*pow(ln(1+exp(3.4*(v(p,k)/103.2+v(gi,k))))/3.4,1.26)-(0.0006177*pow(ln(1+exp(9.901*v(gi,k)))/9.901,1.314)+8.025e-08)
BIG g k I=0.0006177*pow(ln(1+exp(9.901*v(gi,k)))/9.901,1.314)+8.025e-08
RSHOT ns 0 1413.096008
ESHOT gi g ns 0 1
.options reltol=1e-7 abstol=1e-10 vntol=1e-10
.control
op
noise v(o) VIN dec 20 10 40000
setplot noise1
wrdata out.txt onoise_spectrum
.endc
.end
