* Sonora SPICE reference: tube stage noise and hum, chain-60hz
* Generated by sonora-dsp-measure --spice-generate --spice-kind noise from common/dsp
* triode.h and supply.h; do not edit (plugins/native/measure/include/sonora/measure/spice_noise.h).
VRES res 0 DC 290 AC 1
R1 res n1 10000
C2 n1 0 2.2e-05
R2 n1 bp 10000
C3 bp 0 2.2e-05
IOTH bp 0 DC 0.001204493021
VIN in 0 DC 0
CIN in a 2.2e-08
RLEAK a 0 1000000
RGRID a g 22000
RK k 0 1500
CK k 0 2.2e-05
RP bp p 100000
COUT p o 2.2e-08
RL o 0 1000000
CGP g p 2.4e-12
BIP p k I=0.002242*pow(ln(1+exp(3.4*(v(p,k)/103.2+v(g,k))))/3.4,1.26)-(0.0006177*pow(ln(1+exp(9.901*v(g,k)))/9.901,1.314)+8.025e-08)
BIG g k I=0.0006177*pow(ln(1+exp(9.901*v(g,k)))/9.901,1.314)+8.025e-08
.options reltol=1e-7 abstol=1e-10 vntol=1e-10
.control
op
ac lin 9 120 1080
wrdata out.txt v(o)
.endc
.end
