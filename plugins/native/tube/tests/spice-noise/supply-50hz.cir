* Sonora SPICE reference: tube stage noise and hum, supply-50hz
* Generated by sonora-dsp-measure --spice-generate --spice-kind noise from common/dsp
* triode.h and supply.h; do not edit (plugins/native/measure/include/sonora/measure/spice_noise.h).
VS s1 s2 SIN(0 307.5 50)
RW s1 s1r 50
RFL s2 0 1e9
D1 s1r res DR
D2 s2 res DR
D3 0 s1r DR
D4 0 s2 DR
.model DR D(IS=1e-08 N=1.9)
C1 res 0 4.7e-05 IC=290.0250782
IOUT res 0 DC 0.04
R1 res n1 10000
C2 n1 0 2.2e-05 IC=270.0250782
R2 n1 node 10000
C3 node 0 2.2e-05 IC=250.0250782
IPRE node 0 DC 0.002
.options reltol=1e-7 abstol=1e-10 vntol=1e-10 method=trap
.control
tran 5e-06 0.7 0.59999 5e-06 uic
wrdata out.txt v(res)
.endc
.end
