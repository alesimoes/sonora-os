* Sonora SPICE reference: common-cathode triode stage, koren-1v-1000hz
* Generated by sonora-dsp-measure --spice-generate from common/dsp/triode.h;
* do not edit (plugins/native/measure/include/sonora/measure/spice.h).
VIN in 0 SIN(0 1 1000)
VBP bp 0 DC 250
CIN in a 2.2e-08
RLEAK a 0 1000000
RGRID a g 22000
RK k 0 1500
CK k 0 2.2e-05
RP bp p 100000
COUT p o 2.2e-08
RL o 0 1000000
CGP g p 2.4e-12
BIP p k I=((v(p,k)/600*(max(600*(1/100+v(g,k)/sqrt(300+v(p,k)*v(p,k))),0)+ln(1+exp(-abs(600*(1/100+v(g,k)/sqrt(300+v(p,k)*v(p,k))))))))>0)?(2*pow((v(p,k)/600*(max(600*(1/100+v(g,k)/sqrt(300+v(p,k)*v(p,k))),0)+ln(1+exp(-abs(600*(1/100+v(g,k)/sqrt(300+v(p,k)*v(p,k)))))))),1.4)/1060):0
BIG g k I=(v(g,k)>0)?(v(g,k)/2000):0
.options reltol=1e-7 abstol=1e-10 vntol=1e-10 method=trap
.control
op
wrdata op.txt v(a) v(g) v(k) v(p)
tran 5e-07 0.35 0.299999 5e-07
wrdata out.txt v(o)
.endc
.end
