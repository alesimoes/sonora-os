* Sonora SPICE reference: common-cathode triode stage, dempwolf-1v-100hz
* Generated by sonora-dsp-measure --spice-generate from common/dsp/triode.h;
* do not edit (plugins/native/measure/include/sonora/measure/spice.h).
VIN in 0 SIN(0 1 100)
VBP bp 0 DC 250
CIN in a 2.2e-08
RLEAK a 0 1000000
RGRID a g 22000
RK k 0 1500
CK k 0 2.2e-05
RP bp p 100000
COUT p o 2.2e-08
RL o 0 1000000
CGP g p 2.4e-12
BIP p k I=0.002242*pow(ln(1+exp(3.4*(v(p,k)/103.2+v(g,k))))/3.4,1.26)-(0.0006177*pow(ln(1+exp(9.901*v(g,k)))/9.901,1.314)+8.025e-08)
BIG g k I=0.0006177*pow(ln(1+exp(9.901*v(g,k)))/9.901,1.314)+8.025e-08
.options reltol=1e-7 abstol=1e-10 vntol=1e-10 method=trap
.control
op
wrdata op.txt v(a) v(g) v(k) v(p)
tran 5e-06 0.35 0.29999 5e-06
wrdata out.txt v(o)
.endc
.end
